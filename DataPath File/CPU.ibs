| / 7\'7
| \ \   Xilinx Inc.
| / /
| \_\/.\   IBIS Models for SPARTAN-6
[IBIS ver]   4.2
[File name]   CPU.ibs
[File Rev]   1.3
[Date]   Sat May 27 23:10:33 2023
[Source]   Derived from spice models, rev0.21, using
   hspice 2007.12
[Notes]   Xilinx IBIS file for SPARTAN-6 I/O standards.
   All models are preliminary.
   The version of IBISCHK used is ibischk4.
   Ibis models were generated using S2IBIS3.
[Disclaimer] The data in this file is derived from SPICE simulations using
                 modeling information extracted from the target process. While
                 a great deal of care has been taken to provide information
                 that is accurate, this model is considered preliminary as it
                 has not been verified by actual silicon measurement. Treat the
                 data in this model as preliminary until actual silicon
                 verification is performed.
[Copyright]   Copyright 2009, 2010, Xilinx Inc., All rights reserved
|   Component SPARTAN-6
[Component]   SPARTAN-6
[Manufacturer]   Xilinx Inc.
[Package]
|CSG324
|variable   typ   min   max
R_pkg   115.02m   53.54m   220.96m
L_pkg   4.09nH   1.70nH   9.73nH
C_pkg   1.04pF   0.60pF   1.51pF
[Pin]  signal_name   model_name
D4   PC<0>   LVCMOS25_S_12_TB_25
C4   PC<1>   LVCMOS25_S_12_TB_25
B2   PC<2>   LVCMOS25_S_12_TB_25
A2   PC<3>   LVCMOS25_S_12_TB_25
B4   PC<4>   LVCMOS25_S_12_TB_25
C6   PC<5>   LVCMOS25_S_12_TB_25
B3   PC<6>   LVCMOS25_S_12_TB_25
A5   PC<7>   LVCMOS25_S_12_TB_25
F7   PC<8>   LVCMOS25_S_12_TB_25
A4   PC<9>   LVCMOS25_S_12_TB_25
C10   WD<0>   LVCMOS25_S_12_TB_25
A9   WD<1>   LVCMOS25_S_12_TB_25
G8   WD<2>   LVCMOS25_S_12_TB_25
F8   WD<3>   LVCMOS25_S_12_TB_25
D9   WD<4>   LVCMOS25_S_12_TB_25
C9   WD<5>   LVCMOS25_S_12_TB_25
G11   WD<6>   LVCMOS25_S_12_TB_25
F10   WD<7>   LVCMOS25_S_12_TB_25
D11   WD<8>   LVCMOS25_S_12_TB_25
C11   WD<9>   LVCMOS25_S_12_TB_25
K3   clock   LVCMOS25_S_12_LR_25
E7   IFID_IR<0>   LVCMOS25_S_12_TB_25
E8   IFID_IR<1>   LVCMOS25_S_12_TB_25
C7   IFID_IR<2>   LVCMOS25_S_12_TB_25
A7   IFID_IR<3>   LVCMOS25_S_12_TB_25
D8   IFID_IR<4>   LVCMOS25_S_12_TB_25
C8   IFID_IR<5>   LVCMOS25_S_12_TB_25
B8   IFID_IR<6>   LVCMOS25_S_12_TB_25
A8   IFID_IR<7>   LVCMOS25_S_12_TB_25
B11   IFID_IR<8>   LVCMOS25_S_12_TB_25
A11   IFID_IR<9>   LVCMOS25_S_12_TB_25
F14   EXMEM_IR<0>   LVCMOS25_S_12_LR_25
G14   EXMEM_IR<1>   LVCMOS25_S_12_LR_25
D17   EXMEM_IR<2>   LVCMOS25_S_12_LR_25
D18   EXMEM_IR<3>   LVCMOS25_S_12_LR_25
H12   EXMEM_IR<4>   LVCMOS25_S_12_LR_25
G13   EXMEM_IR<5>   LVCMOS25_S_12_LR_25
E16   EXMEM_IR<6>   LVCMOS25_S_12_LR_25
E18   EXMEM_IR<7>   LVCMOS25_S_12_LR_25
K12   EXMEM_IR<8>   LVCMOS25_S_12_LR_25
K13   EXMEM_IR<9>   LVCMOS25_S_12_LR_25
G16   MEMWB_IR<0>   LVCMOS25_S_12_LR_25
G18   MEMWB_IR<1>   LVCMOS25_S_12_LR_25
J13   MEMWB_IR<2>   LVCMOS25_S_12_LR_25
K14   MEMWB_IR<3>   LVCMOS25_S_12_LR_25
L12   MEMWB_IR<4>   LVCMOS25_S_12_LR_25
L13   MEMWB_IR<5>   LVCMOS25_S_12_LR_25
K15   MEMWB_IR<6>   LVCMOS25_S_12_LR_25
K16   MEMWB_IR<7>   LVCMOS25_S_12_LR_25
L15   MEMWB_IR<8>   LVCMOS25_S_12_LR_25
L16   MEMWB_IR<9>   LVCMOS25_S_12_LR_25
F12   IDEX_IR<0>   LVCMOS25_S_12_TB_25
E12   IDEX_IR<1>   LVCMOS25_S_12_TB_25
B14   IDEX_IR<2>   LVCMOS25_S_12_TB_25
C5   PC<10>   LVCMOS25_S_12_TB_25
A14   IDEX_IR<3>   LVCMOS25_S_12_TB_25
A3   PC<11>   LVCMOS25_S_12_TB_25
F13   IDEX_IR<4>   LVCMOS25_S_12_TB_25
D6   PC<12>   LVCMOS25_S_12_TB_25
E13   IDEX_IR<5>   LVCMOS25_S_12_TB_25
E6   PC<13>   LVCMOS25_S_12_TB_25
C15   IDEX_IR<6>   LVCMOS25_S_12_TB_25
B6   PC<14>   LVCMOS25_S_12_TB_25
C14   IDEX_IR<7>   LVCMOS25_S_12_TB_25
A6   PC<15>   LVCMOS25_S_12_TB_25
D14   IDEX_IR<8>   LVCMOS25_S_12_TB_25
A15   IDEX_IR<9>   LVCMOS25_S_12_TB_25
F11   WD<10>   LVCMOS25_S_12_TB_25
E11   WD<11>   LVCMOS25_S_12_TB_25
G9   WD<12>   LVCMOS25_S_12_TB_25
F9   WD<13>   LVCMOS25_S_12_TB_25
C13   WD<14>   LVCMOS25_S_12_TB_25
A13   WD<15>   LVCMOS25_S_12_TB_25
B12   IFID_IR<10>   LVCMOS25_S_12_TB_25
A12   IFID_IR<11>   LVCMOS25_S_12_TB_25
B9   IFID_IR<12>   LVCMOS25_S_12_TB_25
D12   IFID_IR<13>   LVCMOS25_S_12_TB_25
A10   IFID_IR<14>   LVCMOS25_S_12_TB_25
C12   IFID_IR<15>   LVCMOS25_S_12_TB_25
F17   EXMEM_IR<10>   LVCMOS25_S_12_LR_25
F18   EXMEM_IR<11>   LVCMOS25_S_12_LR_25
H13   EXMEM_IR<12>   LVCMOS25_S_12_LR_25
H14   EXMEM_IR<13>   LVCMOS25_S_12_LR_25
H15   EXMEM_IR<14>   LVCMOS25_S_12_LR_25
H16   EXMEM_IR<15>   LVCMOS25_S_12_LR_25
H17   MEMWB_IR<10>   LVCMOS25_S_12_LR_25
H18   MEMWB_IR<11>   LVCMOS25_S_12_LR_25
J16   MEMWB_IR<12>   LVCMOS25_S_12_LR_25
J18   MEMWB_IR<13>   LVCMOS25_S_12_LR_25
K17   MEMWB_IR<14>   LVCMOS25_S_12_LR_25
K18   MEMWB_IR<15>   LVCMOS25_S_12_LR_25
B16   IDEX_IR<10>   LVCMOS25_S_12_TB_25
A16   IDEX_IR<11>   LVCMOS25_S_12_TB_25
F15   IDEX_IR<12>   LVCMOS25_S_12_LR_25
F16   IDEX_IR<13>   LVCMOS25_S_12_LR_25
C17   IDEX_IR<14>   LVCMOS25_S_12_LR_25
C18   IDEX_IR<15>   LVCMOS25_S_12_LR_25
L17   FCS_B_M1DQ2   NC
L18   FOE_B_M1DQ3   NC
M16   FWE_B_M1DQ0   NC
M18   LDC_M1DQ1   NC
N17   HDC_M1DQ8   NC
N18   M1DQ9   NC
P17   M1DQ10   NC
P18   M1DQ11   NC
N15   M1UDQS   NC
N16   M1UDQSN   NC
T17   M1DQ12   NC
T18   M1DQ13   NC
U17   M1DQ14   NC
U18   M1DQ15   NC
M14   IO_L53P_1   NC
N14   IO_L53N_VREF_1   NC
L14   IO_L61P_1   NC
M13   IO_L61N_1   NC
P15   AWAKE   LVCMOS25_S_8_TB_25
P16   DOUT_BUSY   LVCMOS25_S_8_TB_25
R15   CCLK   LVCMOS25_S_8_TB_25
T15   M0_CMPMISO   NC
U16   CMPCLK   NC
V16   CMPMOSI   NC
R13   D0_DIN_MISO_MISO1   LVCMOS25_S_8_TB_25
T13   MOSI_CSI_B_MISO0   LVCMOS25_S_8_TB_25
U15   IO_L5P_2   NC
V15   IO_L5N_2   NC
T14   D1_MISO2   LVCMOS25_S_8_TB_25
V14   D2_MISO3   LVCMOS25_S_8_TB_25
N12   M1   LVCMOS25_S_8_TB_25
P12   D10   LVCMOS25_S_8_TB_25
U13   D11   LVCMOS25_S_8_TB_25
V13   D12   LVCMOS25_S_8_TB_25
M11   IO_L15P_2   NC
N11   IO_L15N_2   NC
R11   IO_L16P_2   NC
T11   IO_L16N_VREF_2   NC
T12   IO_L19P_2   NC
V12   IO_L19N_2   NC
N10   IO_L20P_2   NC
P11   IO_L20N_2   NC
M10   IO_L22P_2   NC
N9   IO_L22N_2   NC
U11   IO_L23P_2   NC
V11   IO_L23N_2   NC
R10   GCLK3   NC
T10   GCLK2   NC
U10   GCLK1_D13   NC
V10   GCLK0_USERCCLK   NC
R8   GCLK31_D14   NC
T8   GCLK30_D15   NC
T9   GCLK29   NC
V9   GCLK28   NC
M8   IO_L40P_2   NC
N8   IO_L40N_2   NC
U8   IO_L41P_2   NC
V8   IO_L41N_VREF_2   NC
U7   IO_L43P_2   NC
V7   IO_L43N_2   NC
N7   IO_L44P_2   NC
P8   IO_L44N_2   NC
T6   IO_L45P_2   NC
V6   IO_L45N_2   NC
R7   IO_L46P_2   NC
T7   IO_L46N_2   NC
N6   IO_L47P_2   NC
P7   IO_L47N_2   NC
R5   D7   LVCMOS25_S_8_TB_25
T5   RDWR_B   LVCMOS25_S_8_TB_25
U5   D3   LVCMOS25_S_8_TB_25
V5   D4   LVCMOS25_S_8_TB_25
R3   D5   LVCMOS25_S_8_TB_25
T3   D6   LVCMOS25_S_8_TB_25
T4   IO_L63P_2   NC
V4   IO_L63N_2   NC
N5   D8   LVCMOS25_S_8_TB_25
P6   D9   LVCMOS25_S_8_TB_25
U3   INIT_B   LVCMOS25_S_8_TB_25
V3   CSO_B   LVCMOS25_S_8_TB_25
N4   IO_L1P_3   NC
N3   IO_L1N_VREF_3   NC
P4   IO_L2P_3   NC
P3   IO_L2N_3   NC
L6   IO_L31P_3   NC
M5   IO_L31N_VREF_3   NC
U2   M3DQ14   NC
U1   M3DQ15   NC
T2   M3DQ12   NC
T1   M3DQ13   NC
P2   M3UDQS   NC
P1   M3UDQSN   NC
N2   M3DQ10   NC
N1   M3DQ11   NC
M3   M3DQ8   NC
M1   M3DQ9   NC
L2   M3DQ0   NC
L1   M3DQ1   NC
K2   M3DQ2   NC
K1   M3DQ3   NC
L4   M3LDQS   NC
L3   M3LDQSN   NC
J3   M3DQ6   NC
J1   M3DQ7   NC
H2   GCLK27_M3DQ4   NC
H1   GCLK26_M3DQ5   NC
K4   GCLK25_TRDY2_M3UDM   NC
L5   GCLK23_M3RASN   NC
K5   GCLK22_IRDY2_M3CASN  NC
H4   GCLK21_M3A5   NC
H3   GCLK20_M3A6   NC
L7   M3A3   NC
K6   M3ODT   NC
G3   M3CLK   NC
G1   M3CLKN   NC
J7   M3A0   NC
J6   M3A1   NC
F2   M3BA0   NC
F1   M3BA1   NC
H6   M3A7   NC
H5   M3A2   NC
E3   M3WE   NC
E1   M3BA2   NC
F4   M3A10   NC
F3   M3A4   NC
D2   M3A8   NC
D1   M3A9   NC
H7   M3CKE   NC
G6   M3A12   NC
E4   M3RESET   NC
D3   M3A11   NC
F6   M3A13   NC
F5   M3A14   NC
C2   IO_L83P_3   NC
C1   IO_L83N_VREF_3   NC
A17   TCK   LVCMOS25_S_8_TB_25
D15   TDI   LVCMOS25_S_8_TB_25
B18   TMS   LVCMOS25_S_8_TB_25
D16   TDO   LVCMOS25_S_8_TB_25
R16   SUSPEND   LVCMOS25_S_8_TB_25
P13   CMPCS_B_2   NC
V17   DONE_2   LVCMOS25_S_8_TB_25
V2   PROGRAM_B_2   LVCMOS25_S_8_TB_25
A1   GND   GND
A18   GND   GND
B13   GND   GND
B7   GND   GND
C16   GND   GND
C3   GND   GND
D10   GND   GND
D5   GND   GND
E15   GND   GND
G12   GND   GND
G17   GND   GND
G2   GND   GND
G5   GND   GND
H10   GND   GND
H8   GND   GND
J11   GND   GND
J15   GND   GND
J4   GND   GND
J9   GND   GND
K10   GND   GND
K8   GND   GND
L11   GND   GND
L9   GND   GND
M17   GND   GND
M2   GND   GND
M6   GND   GND
N13   GND   GND
R1   GND   GND
R14   GND   GND
R18   GND   GND
R4   GND   GND
R9   GND   GND
T16   GND   GND
U12   GND   GND
U6   GND   GND
V1   GND   GND
V18   GND   GND
B10   VCCO_0   POWER
B15   VCCO_0   POWER
B5   VCCO_0   POWER
D13   VCCO_0   POWER
D7   VCCO_0   POWER
E10   VCCO_0   POWER
G7   VCCINT   POWER
H11   VCCINT   POWER
H9   VCCINT   POWER
J10   VCCINT   POWER
J8   VCCINT   POWER
K11   VCCINT   POWER
K9   VCCINT   POWER
L10   VCCINT   POWER
L8   VCCINT   POWER
M12   VCCINT   POWER
M7   VCCINT   POWER
B1   VCCAUX   POWER
B17   VCCAUX   POWER
E14   VCCAUX   POWER
E5   VCCAUX   POWER
E9   VCCAUX   POWER
G10   VCCAUX   POWER
J12   VCCAUX   POWER
K7   VCCAUX   POWER
M9   VCCAUX   POWER
P10   VCCAUX   POWER
P14   VCCAUX   POWER
P5   VCCAUX   POWER
E17   VCCO_1   POWER
G15   VCCO_1   POWER
J14   VCCO_1   POWER
J17   VCCO_1   POWER
M15   VCCO_1   POWER
R17   VCCO_1   POWER
P9   VCCO_2   POWER
R12   VCCO_2   POWER
R6   VCCO_2   POWER
U14   VCCO_2   POWER
U4   VCCO_2   POWER
U9   VCCO_2   POWER
E2   VCCO_3   POWER
G4   VCCO_3   POWER
J2   VCCO_3   POWER
J5   VCCO_3   POWER
M4   VCCO_3   POWER
R2   VCCO_3   POWER
[Package Model]   csg324_xc6slx16
[Diff Pin]   inv_Pin   vdiff   tdelay_typ   tdelay_min   tdelay_max
[Series Pin Mapping] pin_2   model_name   function_table_group
[Define Package Model]   csg324_xc6slx16
[Manufacturer]   Xilinx Inc.
[OEM]   Xilinx_S1
[Description]   246-pin Package
|[Number of Sections]   1
[Number of Pins]   246
[Pin Numbers]
|[Pin Name]  Net Number   Net Name   Net's All Pins
B1   | 1   VCCAUX   B1
   |B17
   |E14
   |E5
   |E9
   |G10
   |J12
   |K7
   |M9
   |P10
   |P14
   |P5
G7   | 2   VCCINT   G7
   |H11
   |H9
   |J10
   |J8
   |K11
   |K9
   |L10
   |L8
   |M12
   |M7
B10   | 3   VCCO_0   B10
   |B15
   |B5
   |D13
   |D7
   |E10
E17   | 4   VCCO_1   E17
   |G15
   |J14
   |J17
   |M15
   |R17
P9   | 5   VCCO_2   P9
   |R12
   |R6
   |U14
   |U4
   |U9
E2   | 6   VCCO_3   E2
   |G4
   |J2
   |J5
   |M4
   |R2
P13   | 7   CMP_CS_B   P13
V17   | 8   DONE   V17
C4   | 9   IO_L01N_0/IREF/VREF_0   C4
F16   | 10   IO_L01N_1/A24/VREF_1   F16
T15   | 11   IO_L01N_2/M0/CMP_MISO   T15
N3   | 12   IO_L01N_3/VREF_3   N3
D4   | 13   IO_L01P_0/HSWAPEN   D4
F15   | 14   IO_L01P_1/A25   F15
R15   | 15   IO_L01P_2/CCLK   R15
N4   | 16   IO_L01P_3/VBG   N4
A2   | 17   IO_L02N_0   A2
C18   | 18   IO_L02N_1/A22/M1A14   C18
V16   | 19   IO_L02N_2/CMP_MOSI   V16
P3   | 20   IO_L02N_3/VTEMP   P3
B2   | 21   IO_L02P_0   B2
C17   | 22   IO_L02P_1/A23/M1A13   C17
U16   | 23   IO_L02P_2/CMP_CLK   U16
P4   | 24   IO_L02P_3/VGG   P4
C6   | 25   IO_L03N_0   C6
G14   | 26   IO_L03N_1/A20/M1A11   G14
T13   | 27   IO_L03N_2/MOSI/CSI_B/MISO1   T13
M5   | 28   IO_L03N_3/VREF_3   M5
D6   | 29   IO_L03P_0   D6
F14   | 30   IO_L03P_1/A21/M1RESET   F14
R13   | 31   IO_L03P_2/D0/DIN/MISO0   R13
L6   | 32   IO_L03P_3   L6
A3   | 33   IO_L04N_0   A3
D18   | 34   IO_L04N_1/A18/M1A12   D18
V15   | 35   IO_L04N_2   V15
U1   | 36   IO_L04N_3/M3DQ15   U1
B3   | 37   IO_L04P_0   B3
D17   | 38   IO_L04P_1/A19/M1CKE   D17
U15   | 39   IO_L04P_2   U15
U2   | 40   IO_L04P_3/M3DQ14   U2
A4   | 41   IO_L05N_0   A4
G13   | 42   IO_L05N_1/A16/M1A9   G13
V14   | 43   IO_L05N_2/D2/MISO3   V14
T1   | 44   IO_L05N_3/M3DQ13   T1
B4   | 45   IO_L05P_0   B4
H12   | 46   IO_L05P_1/A17/M1A8   H12
T14   | 47   IO_L05P_2/D1/MISO2   T14
T2   | 48   IO_L05P_3/M3DQ12   T2
A5   | 49   IO_L06N_0   A5
E18   | 50   IO_L06N_1/A14/M1A4   E18
P12   | 51   IO_L06N_2/D10   P12
P1   | 52   IO_L06N_3/M3UDQSN   P1
C5   | 53   IO_L06P_0   C5
E16   | 54   IO_L06P_1/A15/M1A10   E16
N12   | 55   IO_L06P_2/M1   N12
P2   | 56   IO_L06P_3/M3UDQS   P2
E6   | 57   IO_L07N_0   E6
K13   | 58   IO_L07N_1/A12/M1BA2   K13
V13   | 59   IO_L07N_2/D12   V13
N1   | 60   IO_L07N_3/M3DQ11   N1
F7   | 61   IO_L07P_0   F7
K12   | 62   IO_L07P_1/A13/M1WE   K12
U13   | 63   IO_L07P_2/D11   U13
N2   | 64   IO_L07P_3/M3DQ10   N2
A6   | 65   IO_L08N_0/VREF_0   A6
F18   | 66   IO_L08N_1/A10/M1A2   F18
N11   | 67   IO_L08N_2   N11
M1   | 68   IO_L08N_3/M3DQ9   M1
B6   | 69   IO_L08P_0   B6
F17   | 70   IO_L08P_1/A11/M1A7   F17
M11   | 71   IO_L08P_2   M11
M3   | 72   IO_L08P_3/M3DQ8   M3
E8   | 73   IO_L09N_0   E8
H14   | 74   IO_L09N_1/A8/M1BA1   H14
T11   | 75   IO_L09N_2/VREF_2   T11
L1   | 76   IO_L09N_3/M3DQ1   L1
E7   | 77   IO_L09P_0   E7
H13   | 78   IO_L09P_1/A9/M1BA0   H13
R11   | 79   IO_L09P_2   R11
L2   | 80   IO_L09P_3/M3DQ0   L2
A7   | 81   IO_L10N_0   A7
H16   | 82   IO_L10N_1/A6/M1A1   H16
V12   | 83   IO_L10N_2   V12
K1   | 84   IO_L10N_3/M3DQ3   K1
C7   | 85   IO_L10P_0   C7
H15   | 86   IO_L10P_1/A7/M1A0   H15
T12   | 87   IO_L10P_2   T12
K2   | 88   IO_L10P_3/M3DQ2   K2
C8   | 89   IO_L11N_0   C8
G18   | 90   IO_L11N_1/A4/M1CLKN   G18
P11   | 91   IO_L11N_2   P11
L3   | 92   IO_L11N_3/M3LDQSN   L3
D8   | 93   IO_L11P_0   D8
G16   | 94   IO_L11P_1/A5/M1CLK   G16
N10   | 95   IO_L11P_2   N10
L4   | 96   IO_L11P_3/M3LDQS   L4
F8   | 97   IO_L12N_0   F8
K14   | 98   IO_L12N_1/M1ODT   K14
N9   | 99   IO_L12N_2   N9
J1   | 100   IO_L12N_3/M3DQ7   J1
G8   | 101   IO_L12P_0   G8
J13   | 102   IO_L12P_1/M1A3   J13
M10   | 103   IO_L12P_2   M10
J3   | 104   IO_L12P_3/M3DQ6   J3
A8   | 105   IO_L13N_0   A8
L13   | 106   IO_L13N_1/GCLK10/M1A6   L13
V11   | 107   IO_L13N_2   V11
H1   | 108   IO_L13N_3/GCLK26/M3DQ5   H1
B8   | 109   IO_L13P_0   B8
L12   | 110   IO_L13P_1/GCLK11/M1A5   L12
U11   | 111   IO_L13P_2   U11
H2   | 112   IO_L13P_3/GCLK27/M3DQ4   H2
C9   | 113   IO_L14N_0/GCLK18   C9
K16   | 114   IO_L14N_1/GCLK8/M1CASN   K16
T10   | 115   IO_L14N_2/GCLK2   T10
K3   | 116   IO_L14N_3/GCLK24/M3LDM   K3
D9   | 117   IO_L14P_0/GCLK19   D9
K15   | 118   IO_L14P_1/GCLK9/IRDY1/M1RASN   K15
R10   | 119   IO_L14P_2/GCLK3   R10
K4   | 120   IO_L14P_3/GCLK25/TRDY2/M3UDM   K4
A9   | 121   IO_L15N_0/GCLK16   A9
L16   | 122   IO_L15N_1/GCLK6/TRDY1/M1LDM   L16
V10   | 123   IO_L15N_2/GCLK0/CFGMCLK   V10
K5   | 124   IO_L15N_3/GCLK22/IRDY2/M3CASN   K5
B9   | 125   IO_L15P_0/GCLK17   B9
L15   | 126   IO_L15P_1/GCLK7/M1UDM   L15
U10   | 127   IO_L15P_2/GCLK1/D13   U10
L5   | 128   IO_L15P_3/GCLK23/M3RASN   L5
C11   | 129   IO_L16N_0/GCLK14   C11
H18   | 130   IO_L16N_1/GCLK4/M1DQ5   H18
T8   | 131   IO_L16N_2/GCLK30/D15   T8
H3   | 132   IO_L16N_3/GCLK20/M3A6   H3
D11   | 133   IO_L16P_0/GCLK15   D11
H17   | 134   IO_L16P_1/GCLK5/M1DQ4   H17
R8   | 135   IO_L16P_2/GCLK31/D14   R8
H4   | 136   IO_L16P_3/GCLK21/M3A5   H4
A10   | 137   IO_L17N_0/GCLK12   A10
J18   | 138   IO_L17N_1/A2/M1DQ7   J18
V9   | 139   IO_L17N_2/GCLK28   V9
K6   | 140   IO_L17N_3/M3ODT   K6
C10   | 141   IO_L17P_0/GCLK13   C10
J16   | 142   IO_L17P_1/A3/M1DQ6   J16
T9   | 143   IO_L17P_2/GCLK29   T9
L7   | 144   IO_L17P_3/M3A3   L7
F9   | 145   IO_L18N_0/VREF_0   F9
K18   | 146   IO_L18N_1/A0/M1LDQSN   K18
N8   | 147   IO_L18N_2   N8
G1   | 148   IO_L18N_3/M3CLKN   G1
G9   | 149   IO_L18P_0   G9
K17   | 150   IO_L18P_1/A1/M1LDQS   K17
M8   | 151   IO_L18P_2   M8
G3   | 152   IO_L18P_3/M3CLK   G3
A11   | 153   IO_L19N_0   A11
L18   | 154   IO_L19N_1/FOE_B/M1DQ3   L18
V8   | 155   IO_L19N_2/VREF_2   V8
J6   | 156   IO_L19N_3/M3A1   J6
B11   | 157   IO_L19P_0   B11
L17   | 158   IO_L19P_1/FCS_B/M1DQ2   L17
U8   | 159   IO_L19P_2   U8
J7   | 160   IO_L19P_3/M3A0   J7
F10   | 161   IO_L20N_0   F10
M18   | 162   IO_L20N_1/LDC/M1DQ1   M18
V7   | 163   IO_L20N_2   V7
F1   | 164   IO_L20N_3/M3BA1   F1
G11   | 165   IO_L20P_0   G11
M16   | 166   IO_L20P_1/FWE_B/M1DQ0   M16
U7   | 167   IO_L20P_2   U7
F2   | 168   IO_L20P_3/M3BA0   F2
A12   | 169   IO_L21N_0   A12
N18   | 170   IO_L21N_1/M1DQ9   N18
P8   | 171   IO_L21N_2   P8
H5   | 172   IO_L21N_3/M3A2   H5
B12   | 173   IO_L21P_0   B12
N17   | 174   IO_L21P_1/HDC/M1DQ8   N17
N7   | 175   IO_L21P_2   N7
H6   | 176   IO_L21P_3/M3A7   H6
E11   | 177   IO_L22N_0   E11
P18   | 178   IO_L22N_1/M1DQ11   P18
V6   | 179   IO_L22N_2   V6
E1   | 180   IO_L22N_3/M3BA2   E1
F11   | 181   IO_L22P_0   F11
P17   | 182   IO_L22P_1/M1DQ10   P17
T6   | 183   IO_L22P_2   T6
E3   | 184   IO_L22P_3/M3WE   E3
C12   | 185   IO_L23N_0   C12
N16   | 186   IO_L23N_1/M1UDQSN   N16
T7   | 187   IO_L23N_2   T7
F3   | 188   IO_L23N_3/M3A4   F3
D12   | 189   IO_L23P_0   D12
N15   | 190   IO_L23P_1/M1UDQS   N15
R7   | 191   IO_L23P_2   R7
F4   | 192   IO_L23P_3/M3A10   F4
A13   | 193   IO_L24N_0   A13
T18   | 194   IO_L24N_1/M1DQ13   T18
P7   | 195   IO_L24N_2   P7
D1   | 196   IO_L24N_3/M3A9   D1
C13   | 197   IO_L24P_0   C13
T17   | 198   IO_L24P_1/M1DQ12   T17
N6   | 199   IO_L24P_2   N6
D2   | 200   IO_L24P_3/M3A8   D2
E12   | 201   IO_L25N_0   E12
U18   | 202   IO_L25N_1/M1DQ15   U18
T5   | 203   IO_L25N_2/RDWR_B/VREF_2   T5
G6   | 204   IO_L25N_3/M3A12   G6
F12   | 205   IO_L25P_0   F12
U17   | 206   IO_L25P_1/M1DQ14   U17
R5   | 207   IO_L25P_2/D7   R5
H7   | 208   IO_L25P_3/M3CKE   H7
A14   | 209   IO_L26N_0/VREF_0   A14
N14   | 210   IO_L26N_1/VREF_1   N14
V5   | 211   IO_L26N_2/D4   V5
D3   | 212   IO_L26N_3/M3A11   D3
B14   | 213   IO_L26P_0   B14
M14   | 214   IO_L26P_1   M14
U5   | 215   IO_L26P_2/D3   U5
E4   | 216   IO_L26P_3/M3RESET   E4
E13   | 217   IO_L27N_0/SCP6   E13
M13   | 218   IO_L27N_1   M13
T3   | 219   IO_L27N_2/D6   T3
F5   | 220   IO_L27N_3/M3A14   F5
F13   | 221   IO_L27P_0/SCP7   F13
L14   | 222   IO_L27P_1   L14
R3   | 223   IO_L27P_2/D5   R3
F6   | 224   IO_L27P_3/M3A13   F6
A15   | 225   IO_L28N_0/SCP4   A15
P16   | 226   IO_L28N_1/DOUT/VREF_1   P16
V4   | 227   IO_L28N_2   V4
C1   | 228   IO_L28N_3/VREF_3   C1
C15   | 229   IO_L28P_0/SCP5   C15
P15   | 230   IO_L28P_1/AWAKE   P15
T4   | 231   IO_L28P_2   T4
C2   | 232   IO_L28P_3   C2
C14   | 233   IO_L29N_0/SCP2   C14
P6   | 234   IO_L29N_2/D9   P6
D14   | 235   IO_L29P_0/SCP3   D14
N5   | 236   IO_L29P_2/D8   N5
A16   | 237   IO_L30N_0/SCP0   A16
V3   | 238   IO_L30N_2/CSO_B   V3
B16   | 239   IO_L30P_0/SCP1   B16
U3   | 240   IO_L30P_2/INIT_B   U3
V2   | 241   PROGRAM_B   V2
R16   | 242   SUSPEND   R16
A17   | 243   TCK   A17
D15   | 244   TDI   D15
D16   | 245   TDO   D16
B18   | 246   TMS   B18
[Model Data]
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[End Model Data]
[End Package Model]
| Models and submodels in the file (3): LVCMOS25_S_8_TB_25 (I/O), LVCMOS25_S_12_LR_25 (I/O), LVCMOS25_S_12_TB_25 (I/O)
